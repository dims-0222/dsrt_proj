** sch_path: /foss/designs/dsrt/dsrt_proj/2OTA.sch
.subckt 2OTA vdd plus out minus ibias vss
*.PININFO ibias:I minus:I plus:I vdd:B vss:B out:O
XM1 net2 net1 vdd vdd sky130_fd_pr__pfet_01v8 L=1 W=1.5 nf=1 m=1
XM2 net1 net1 vdd vdd sky130_fd_pr__pfet_01v8 L=1 W=1.5 nf=1 m=1
XM3 net1 minus net3 vss sky130_fd_pr__nfet_01v8 L=1 W=1.5 nf=1 m=1
XM4 net2 plus net3 vss sky130_fd_pr__nfet_01v8 L=1 W=1.5 nf=1 m=1
XM5 ibias ibias vss vss sky130_fd_pr__nfet_01v8 L=1 W=1.5 nf=1 m=1
XM6 net3 ibias vss vss sky130_fd_pr__nfet_01v8 L=1 W=1.5 nf=1 m=1
XM7 out net2 vdd vdd sky130_fd_pr__pfet_01v8 L=1 W=34 nf=4 m=1
XM8 out ibias vss vss sky130_fd_pr__nfet_01v8 L=1 W=13 nf=2 m=1
XC1 out net2 sky130_fd_pr__cap_mim_m3_1 W=7.5 L=7.5 m=2
XC2 out net2 sky130_fd_pr__cap_mim_m3_1 W=7.5 L=7.5 m=2
.ends
